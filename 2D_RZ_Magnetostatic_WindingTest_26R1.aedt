# Ansys Electronics Desktop project, version 2026.1
materials:
  vacuum: permittivity=1
  copper: permeability=0.999991 conductivity=58000000

design Maxwell2DDesign_Solid (Maxwell 2D, Magnetostatic, about Z geometry, model units mm)
notes: This is a simple 2D RZ test model for a ring coil using the solid winding defintion.
options: Notes="This is a simple 2D RZ test model for a ring coil using the solid winding defintion."
geometry:
  Rectangle1 [copper] = rectangle(corner=(0.4mm, 0mm, 0mm), z_size=0.2mm, x_size=2.6mm)
  SubRegion [vacuum] = sub_region(of=Rectangle1, percentage_offset: +X=300, -X=0, +Y=0, -Y=0, +Z=3000, -Z=3000)
  Polyline1 = polyline((0mm, 0mm, 0.1mm) (10.8mm, 0mm, 0.1mm))
  Polyline2 = polyline((0mm, 0mm, -6mm) (0mm, 0mm, 6.2mm))
boundaries and excitations:
  Balloon1: Balloon Edges=SubRegion.edge(at (5.4, 0, 6.2), at (10.8, 0, 0.1), at (5.4, 0, -6))
  VectorPotential1: Vector Potential Edges=SubRegion.edge(at (0, 0, 0.1)) Value=0
  Rectangle1: Coil Objects=Rectangle1 Conductor_number=1 Winding=Winding1 PolarityType=Positive
  Winding1: Winding Group Type=Current IsSolid=true Current=1A ParallelBranchesNum=1
setups:
  Setup1: Magnetostatic MaximumPasses=10 MinimumPasses=2 MinimumConvergedPasses=1 PercentRefinement=30 PercentError=0.01 NonLinearResidual=0.0001
field plots:
  Mag_B1: B over Rectangle1, SubRegion on Setup1 : LastAdaptive
  Jphi1, J_Vector1: J over Rectangle1 on Setup1 : LastAdaptive
  Flux_Lines1: A over Rectangle1, SubRegion on Setup1 : LastAdaptive
  Mesh1: MeshPlots over Rectangle1, SubRegion on Setup1 : LastAdaptive
reports:
  Current Density along a Horizontal Line: Jphi vs Distance on Setup1 : LastAdaptive
  Flux Density along Center Line: Mag_B vs Distance on Setup1 : LastAdaptive
  SolidLoss vs Num of Passes: SolidLoss vs Pass on Setup1 : AdaptivePass
